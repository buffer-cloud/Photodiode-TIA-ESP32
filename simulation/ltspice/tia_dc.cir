* TIA DC operating point + DC transfer sweep, vendor OPAx320 model.
* Stepped over gain (gi=1:10k/1n, 2:100k/100p, 3:1Meg/10p).
* Iphoto source is swept directly from dark (2n) up to 2n+300u so that the
* very first sweep point IS the dark operating point (item 1), and the rest
* of the sweep covers 0 -> 2x full-scale for every gain (item 2). Ideal VREF.
.include ../models/OPAx320.lib
.step param gi 1 3 1
.param RF={table(gi,1,10k,2,100k,3,1Meg)}
.param CFsel={table(gi,1,1n,2,100p,3,10p)}
.param CT=80p
VCC vcc 0 3.3
VREF ref 0 1.65
Iphoto vcc sum DC 2n
Cdiode sum vcc {CT-9p}
XU ref sum vcc 0 tia OPAx320
RF sum tia {RF}
CF sum tia {CFsel}
R1 tia f1 3.3k
C1 f1 0 100n
X1 f1 b1 vcc 0 b1 OPAx320
R2 b1 f2 3.3k
C2 f2 0 100n
X2 f2 b2 vcc 0 b2 OPAx320
RADC b2 adc 1k
CADC adc 0 10n
.dc Iphoto 2n 300u 200n
.save V(sum) V(tia) V(b1) V(b2) V(adc) I(VCC)
.end
