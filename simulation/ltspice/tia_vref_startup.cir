* VREF power-up transient. VREF is generated by a resistive divider off VCC
* (10k/10k) buffered by a unity-gain OPAx320 follower with a 1uF output
* filter cap (typical local reference decoupling), so VREF tracks and lags
* the VCC power-up ramp. VCC ramps 0 -> 3.3V over 1ms (typical LDO/regulator
* soft-start) then holds. TIA at representative mid gain (100k/100pF),
* CT=80p nominal, dark current only (2n), to observe V(ref), V(tia), V(adc)
* settle from power-up with no optical signal applied.
.include ../models/OPAx320.lib
VCC vcc 0 PWL(0 0 1m 3.3 600m 3.3)
Rdiv1 vcc dmid 10k
Rdiv2 dmid 0 10k
XREFBUF dmid ref vcc 0 ref OPAx320
Cmid1 dmid 0 10u
Cmid2 dmid 0 100n
Iphoto vcc sum DC 2n
Cdiode sum vcc 71p
XU ref sum vcc 0 tia OPAx320
RF sum tia 100k
CF sum tia 100p
R1 tia f1 3.3k
C1 f1 0 100n
X1 f1 b1 vcc 0 b1 OPAx320
R2 b1 f2 3.3k
C2 f2 0 100n
X2 f2 b2 vcc 0 b2 OPAx320
RADC b2 adc 1k
CADC adc 0 10n
.options plotwinsize=0
.tran 0 600m 0 50u
.save V(vcc) V(ref) V(tia) V(adc)
.end
