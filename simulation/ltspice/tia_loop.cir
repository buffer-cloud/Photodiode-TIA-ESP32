* Loop-gain / phase-margin extraction via single-point voltage injection
* (Middlebrook-style break, valid because the op-amp's real output
* impedance is near-zero relative to the RF/CF+filter load it drives -- the
* single-injection accuracy condition). Method:
*   - The op-amp's real output ("tia_amp") is separated from the external
*     feedback + load node ("tia") by a break element: a very large
*     inductor Lbrk (DC short -> preserves the bias point exactly) in
*     parallel with a very large capacitor Cbrk in series with a unit AC
*     test source Vtest (AC short at all swept frequencies, injects a pure
*     AC perturbation without disturbing DC bias).
*   - With Vtest = AC 1/_0, algebra on the closed loop shows
*         V(tia) = 1/(1+T)                (T = loop gain / return ratio)
*     so the loop gain is recovered in post-processing as T(f) = 1/V(tia) - 1
*     (complex). Phase margin = 180 deg + angle(T) at the 0 dB crossover of
*     |T|. This is documented in simulation/notes/simulation-report.md.
* Iphoto AC is set to 0 (only the injected Vtest excites the loop here).
* Same nested step structure as tia_ac.cir: gi (gain), cfi (CF case),
* cti (CT corner).
.include ../models/OPAx320.lib
.step param gi 1 3 1
.step param cfi 1 6 1
.step param cti 1 3 1
.param RF={table(gi,1,10k,2,100k,3,1Meg)}
.param CFmin={table(gi,1,8p,2,2.5p,3,0.8p)}
.param CFsel={table(gi,1,1n,2,100p,3,10p)}
.param CF={table(cfi,1,0.5*CFmin,2,1*CFmin,3,2*CFmin,4,0.5*CFsel,5,1*CFsel,6,2*CFsel)}
.param CT={table(cti,1,40p,2,80p,3,120p)}
VCC vcc 0 3.3
VREF ref 0 1.65
Iphoto vcc sum DC 2n AC 0
Cdiode sum vcc {CT-9p}
XU ref sum vcc 0 tia_amp OPAx320
Lbrk tia_amp tia 1e12
Cbrk tia_amp cx 1
Vtest cx tia AC 1 0
RF sum tia {RF}
CF sum tia {CF}
R1 tia f1 3.3k
C1 f1 0 100n
X1 f1 b1 vcc 0 b1 OPAx320
R2 b1 f2 3.3k
C2 f2 0 100n
X2 f2 b2 vcc 0 b2 OPAx320
RADC b2 adc 1k
CADC adc 0 10n
.ac dec 100 0.1 100Meg
.save V(tia)
.end
