* TI OPAx320 vendor model TIA, closed-loop AC transimpedance (extends the
* original single-case tia_ac.cir). Nested .step over:
*   gi  = 1..3  gain range (10k/1n, 100k/100p, 1Meg/10p)
*   cfi = 1..6  CF case: 1/2/3 = 0.5x/1x/2x ANALYTICAL-MINIMUM CF (8.0/2.5/0.8p)
*               4/5/6 = 0.5x/1x/2x SELECTED (locked) CF (1n/100p/10p)
*   cti = 1..3  CT corner: 40p / 80p / 120p (total input capacitance incl 9pF
*               op-amp input cap already inside the vendor model, so
*               Cdiode = CT - 9p)
* Reports closed-loop |V(tia)/Iphoto)| and |V(adc)/Iphoto| vs frequency for
* DC gain, peaking, and -3 dB BW extraction in Python.
.include ../models/OPAx320.lib
.step param gi 1 3 1
.step param cfi 1 6 1
.step param cti 1 3 1
.param RF={table(gi,1,10k,2,100k,3,1Meg)}
.param CFmin={table(gi,1,8p,2,2.5p,3,0.8p)}
.param CFsel={table(gi,1,1n,2,100p,3,10p)}
.param CF={table(cfi,1,0.5*CFmin,2,1*CFmin,3,2*CFmin,4,0.5*CFsel,5,1*CFsel,6,2*CFsel)}
.param CT={table(cti,1,40p,2,80p,3,120p)}
VCC vcc 0 3.3
VREF ref 0 1.65
Iphoto vcc sum DC 2n AC 1
Cdiode sum vcc {CT-9p}
XU ref sum vcc 0 tia OPAx320
RF sum tia {RF}
CF sum tia {CF}
R1 tia f1 3.3k
C1 f1 0 100n
X1 f1 b1 vcc 0 b1 OPAx320
R2 b1 f2 3.3k
C2 f2 0 100n
X2 f2 b2 vcc 0 b2 OPAx320
RADC b2 adc 1k
CADC adc 0 10n
.ac dec 100 0.1 100Meg
.save V(tia) V(adc)
.end
