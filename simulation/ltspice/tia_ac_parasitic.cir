* Stability sensitivity: 1 pF feedback-parasitic add-on on the analytical
* minimum CF cases only, per design-contract item 4. CT held at the nominal
* 80 pF corner. Nested .step: gi=1..3 (gain), mi=1..3 (0.5x/1x/2x analytical
* minimum CF, before adding the 1 pF parasitic).
.include ../models/OPAx320.lib
.step param gi 1 3 1
.step param mi 1 3 1
.param RF={table(gi,1,10k,2,100k,3,1Meg)}
.param CFmin={table(gi,1,8p,2,2.5p,3,0.8p)}
.param CFbase={table(mi,1,0.5*CFmin,2,1*CFmin,3,2*CFmin)}
.param CF={CFbase+1p}
.param CT=80p
VCC vcc 0 3.3
VREF ref 0 1.65
Iphoto vcc sum DC 2n AC 1
Cdiode sum vcc {CT-9p}
XU ref sum vcc 0 tia OPAx320
RF sum tia {RF}
CF sum tia {CF}
R1 tia f1 3.3k
C1 f1 0 100n
X1 f1 b1 vcc 0 b1 OPAx320
R2 b1 f2 3.3k
C2 f2 0 100n
X2 f2 b2 vcc 0 b2 OPAx320
RADC b2 adc 1k
CADC adc 0 10n
.ac dec 100 0.1 100Meg
.save V(tia) V(adc)
.end
