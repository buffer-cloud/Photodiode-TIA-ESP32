* Transient step response, vendor OPAx320 model, CT = 80 pF fixed.
* Nested .step:
*   gi     = 1..3  gain range
*   cfi    = 1..2  1 = SELECTED CF (locked), 2 = 1x ANALYTICAL-MINIMUM CF
*   stepi  = 1..3  1 = 10%FS step, 2 = 100%FS (full-scale) step,
*                  3 = 300%FS overload step then a step back down to 1xFS
*                      at t=tmid to observe saturation recovery
* Full-scale current FS = 1.40/RF. Time axis is scaled by cfi because the
* analytical-minimum CF cases have a closed-loop pole ~100x faster than the
* selected (locked) CF cases (RF*CF = 10us for all selected-CF gains vs
* ~0.1-1us for the analytical-minimum CF), so a single time window would
* either be far too short (selected case never settles) or absurdly
* oversampled (analytical case). Edge time is always fast (<<smallest RC).
.include ../models/OPAx320.lib
.step param gi 1 3 1
.step param cfi 1 2 1
.step param stepi 1 3 1
.param RF={table(gi,1,10k,2,100k,3,1Meg)}
.param CFsel={table(gi,1,1n,2,100p,3,10p)}
.param CFmin={table(gi,1,8p,2,2.5p,3,0.8p)}
.param CF={table(cfi,1,CFsel,2,CFmin)}
.param CT=80p
.param Idark=2n
.param FS={1.40/RF}
.param upamp={table(stepi,1,0.1*FS,2,1.0*FS,3,3.0*FS)}
.param downamp={table(stepi,1,0.1*FS,2,1.0*FS,3,1.0*FS)}
.param tedge={table(cfi,1,1u,2,1n)}
.param tmid={table(cfi,1,3m,2,3u)}
.param tend={table(cfi,1,8m,2,8u)}
VCC vcc 0 3.3
VREF ref 0 1.65
Iphoto vcc sum PWL(0 {Idark} {tedge} {Idark+upamp} {tmid} {Idark+upamp} {tmid+tedge} {Idark+downamp} {tend} {Idark+downamp})
Cdiode sum vcc {CT-9p}
XU ref sum vcc 0 tia OPAx320
RF sum tia {RF}
CF sum tia {CF}
R1 tia f1 3.3k
C1 f1 0 100n
X1 f1 b1 vcc 0 b1 OPAx320
R2 b1 f2 3.3k
C2 f2 0 100n
X2 f2 b2 vcc 0 b2 OPAx320
RADC b2 adc 1k
CADC adc 0 10n
.options plotwinsize=0
.tran 0 {tend} 0 {table(cfi,1,200n,2,0.2n)}
.save V(tia) V(adc) V(sum)
.end
